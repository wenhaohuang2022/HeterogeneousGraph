simulator lang=spectre
global 0
include "/home/public/PDK/smic/18/SPDK18MSE_1833_OA_CDS_V1.11_4/smic18mse_1833_oa_cds_v1.11_4/models/spectre/ms018_enhanced_v1p11_spe.lib" section=tt
include "/home/public/PDK/smic/18/SPDK18MSE_1833_OA_CDS_V1.11_4/smic18mse_1833_oa_cds_v1.11_4/models/spectre/ms018_enhanced_v1p11_spe.lib" section=bjt_tt
include "/home/public/PDK/smic/18/SPDK18MSE_1833_OA_CDS_V1.11_4/smic18mse_1833_oa_cds_v1.11_4/models/spectre/ms018_enhanced_v1p11_spe.lib" section=dio_tt
include "/home/public/PDK/smic/18/SPDK18MSE_1833_OA_CDS_V1.11_4/smic18mse_1833_oa_cds_v1.11_4/models/spectre/ms018_enhanced_v1p11_spe.lib" section=res_tt
include "/home/public/PDK/smic/18/SPDK18MSE_1833_OA_CDS_V1.11_4/smic18mse_1833_oa_cds_v1.11_4/models/spectre/ms018_enhanced_v1p11_spe.lib" section=mim_tt
include "/home/public/PDK/smic/18/SPDK18MSE_1833_OA_CDS_V1.11_4/smic18mse_1833_oa_cds_v1.11_4/models/spectre/ms018_enhanced_v1p11_spe.lib" section=var_tt

subckt SMC VINN VINP VOUT IBIAS VDD VSS
NM4 (VOUT IBIAS VSS VSS) n18 w=1.142e-05 l=1.8e-07 m=2 //// Load transistor, 2nd stage
NM0 (net27 VINN net26 VSS) n18 w=1.36e-06 l=1.15e-06 m=1 //// Input transistor, 1st stage ``NM1``
NM3 (IBIAS IBIAS VSS VSS) n18 w=2.3e-07 l=1.8e-07 m=1 //// Bias transistor
NM2 (net26 IBIAS VSS VSS) n18 w=3.8e-07 l=1.9e-07 m=1 //// Current transistor, 1st stage
NM1 (net28 VINP net26 VSS) n18 w=1.36e-06 l=1.15e-06 m=1 //// Input transistor, 1st stage ``NM0``
PM2 (VOUT net28 VDD VDD) p18 w=1.534e-05 l=1.8e-07 m=4 //// Input transistor, 2nd stage
PM1 (net27 net27 VDD VDD) p18 w=1.13e-06 l=6.6e-07 m=1 //// Load transistor, 1st stage ``PM0``
PM0 (net28 net27 VDD VDD) p18 w=1.13e-06 l=6.6e-07 m=1 //// Load transistor, 1st stage ``PM1``
C0 (net28 VOUT) capacitor c=5.05e-13 m=1 //// Miller cap
ends SMC

        parameters PSRR_type = 0 CMRR_type = 0
        V0 (VSS 0) vsource dc=0 type=dc
        V1 (VDD 0) vsource dc=1.8 type=sine mag = PSRR_type
        C0 (VOUT VSS) capacitor c=4e-11
        I0 (VDD IBIAS) isource dc=2e-06 type=dc
        V2 (VINP 0) vsource dc=0.9 type=sine mag = CMRR_type
        V3 (VINN VOUT) vsource dc=0 type=sine mag = CMRR_type
        I1 (VINN VINP VOUT IBIAS VDD VSS) SMC
