simulator lang=spectre
global 0
include "/Business/EDA_yf_company/public/PDK/smic/18/SPDK18MSE_1833_OA_CDS_V1.11_4/smic18mse_1833_1P3M_2Ia_1TMa1_MIM10_oa_cds_2019_01_15_v1.11_4/smic18mmrf/../models/spectre/ms018_enhanced_v1p11_spe.lib" section=tt
include "/Business/EDA_yf_company/public/PDK/smic/18/SPDK18MSE_1833_OA_CDS_V1.11_4/smic18mse_1833_1P3M_2Ia_1TMa1_MIM10_oa_cds_2019_01_15_v1.11_4/smic18mmrf/../models/spectre/ms018_enhanced_v1p11_spe.lib" section=bjt_tt
include "/Business/EDA_yf_company/public/PDK/smic/18/SPDK18MSE_1833_OA_CDS_V1.11_4/smic18mse_1833_1P3M_2Ia_1TMa1_MIM10_oa_cds_2019_01_15_v1.11_4/smic18mmrf/../models/spectre/ms018_enhanced_v1p11_spe.lib" section=dio_tt
include "/Business/EDA_yf_company/public/PDK/smic/18/SPDK18MSE_1833_OA_CDS_V1.11_4/smic18mse_1833_1P3M_2Ia_1TMa1_MIM10_oa_cds_2019_01_15_v1.11_4/smic18mmrf/../models/spectre/ms018_enhanced_v1p11_spe.lib" section=res_tt
include "/Business/EDA_yf_company/public/PDK/smic/18/SPDK18MSE_1833_OA_CDS_V1.11_4/smic18mse_1833_1P3M_2Ia_1TMa1_MIM10_oa_cds_2019_01_15_v1.11_4/smic18mmrf/../models/spectre/ms018_enhanced_v1p11_spe.lib" section=mim_tt
include "/Business/EDA_yf_company/public/PDK/smic/18/SPDK18MSE_1833_OA_CDS_V1.11_4/smic18mse_1833_1P3M_2Ia_1TMa1_MIM10_oa_cds_2019_01_15_v1.11_4/smic18mmrf/../models/spectre/ms018_enhanced_v1p11_spe.lib" section=var_tt

subckt NMCF VINN VINP VOUT IBIAS VDD VSS
NM9 (net041 net035 VSS VSS) n18 w=4.39e-06 l=4.78e-06 m=1 ////**Load** transistor, 2nd stage.
NM7 (IBIASP IBIAS VSS VSS) n18 w=2.2e-07 l=1.8e-07 ////bias transistor. should not be changed
NM6 (IBIAS IBIAS VSS VSS) n18 w=2.2e-07 l=1.8e-07  ////bias transistor. should not be changed
NM4 (VOUT net041 VSS VSS) n18 w=1.819e-05 l=5.8e-07 m=7 ////**Input** transistor, Load(gm3) stage.
NM0 (net27 VINN net26 VSS) n18 w=6.19e-06 l=8.5e-07 m=1 ////**Input** transistor, 1st stage. ``NM1``
NM8 (net035 net035 VSS VSS) n18 w=1.16e-06 l=8.7e-07 m=1 ////**Load** transistor, 2nd stage.
NM2 (net26 IBIAS VSS VSS) n18 w=8.3e-06 l=3.78e-06 m=1 ////current tail transistor, 1st stage
NM1 (net28 VINP net26 VSS) n18 w=6.19e-06 l=8.5e-07 m=1 ////**Input** transistor, 1st stage. ``NM0``
PM9 (VOUT net28 VDD VDD) p18 w=9.2e-06 l=3.4e-07 m=1 ////the **Input** transistor, gmf2 stage.
PM8 (net035 net28 VDD VDD) p18 w=9.68e-06 l=1.46e-06 m=1 ////**Input** transistor, 2nd stage.
PM7 (net041 IBIASP VDD VDD) p18 w=1.75e-06 l=2e-07 m=1 ////**Load** transistor, 2nd stage.
PM6 (IBIASP IBIASP VDD VDD) p18 w=2.2e-07 l=1.8e-07 ////bias transistor. should not be changed
PM2 (VOUT IBIASP VDD VDD) p18 w=1.951e-05 l=2e-07 m=7 ////**Load** transistor, Load(gm3) stage.
PM1 (net27 net27 VDD VDD) p18 w=1.57e-06 l=6.7e-07 m=1 ////**Load** transistor, 1st(gm1) stage. ``PM0``
PM0 (net28 net27 VDD VDD) p18 w=1.57e-06 l=6.7e-07 m=1 ////**Load** transistor, 1st(gm1) stage. ``PM1``
C1 (net041 VOUT) capacitor c=9.63e-13 m=1 ////miller cap 2
C0 (net28 VOUT) capacitor c=9.2e-13 m=1 ////miller cap 1
ends NMCF

            V0 (VSS 0) vsource dc=0 type=dc
            V1 (VDD 0) vsource dc=1.8 type=dc
            C0 (VOUT VSS) capacitor c=5e-11
            I0 (VDD IBIAS) isource dc=1e-06 type=dc
            I1 (VOUT VINP VOUT IBIAS VDD VSS) NMCF
            V2 (VINP 0) vsource type=pulse val0=1.2 val1=0.6 period=3.3333333333333335e-05 rise=1p fall=1p
