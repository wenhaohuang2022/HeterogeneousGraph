simulator lang=spectre
global 0
include "/Business/EDA_yf_company/public/PDK/smic/18/SPDK18MSE_1833_OA_CDS_V1.11_4/smic18mse_1833_1P3M_2Ia_1TMa1_MIM10_oa_cds_2019_01_15_v1.11_4/smic18mmrf/../models/spectre/ms018_enhanced_v1p11_spe.lib" section=tt
include "/Business/EDA_yf_company/public/PDK/smic/18/SPDK18MSE_1833_OA_CDS_V1.11_4/smic18mse_1833_1P3M_2Ia_1TMa1_MIM10_oa_cds_2019_01_15_v1.11_4/smic18mmrf/../models/spectre/ms018_enhanced_v1p11_spe.lib" section=bjt_tt
include "/Business/EDA_yf_company/public/PDK/smic/18/SPDK18MSE_1833_OA_CDS_V1.11_4/smic18mse_1833_1P3M_2Ia_1TMa1_MIM10_oa_cds_2019_01_15_v1.11_4/smic18mmrf/../models/spectre/ms018_enhanced_v1p11_spe.lib" section=dio_tt
include "/Business/EDA_yf_company/public/PDK/smic/18/SPDK18MSE_1833_OA_CDS_V1.11_4/smic18mse_1833_1P3M_2Ia_1TMa1_MIM10_oa_cds_2019_01_15_v1.11_4/smic18mmrf/../models/spectre/ms018_enhanced_v1p11_spe.lib" section=res_tt
include "/Business/EDA_yf_company/public/PDK/smic/18/SPDK18MSE_1833_OA_CDS_V1.11_4/smic18mse_1833_1P3M_2Ia_1TMa1_MIM10_oa_cds_2019_01_15_v1.11_4/smic18mmrf/../models/spectre/ms018_enhanced_v1p11_spe.lib" section=mim_tt
include "/Business/EDA_yf_company/public/PDK/smic/18/SPDK18MSE_1833_OA_CDS_V1.11_4/smic18mse_1833_1P3M_2Ia_1TMa1_MIM10_oa_cds_2019_01_15_v1.11_4/smic18mmrf/../models/spectre/ms018_enhanced_v1p11_spe.lib" section=var_tt

subckt TCFC VINN VINP VOUT IBIAS1 IBIAS2 VDD VSS
PM11 (net047 IBIASP1 VDD VDD) p18 w=2.2e-07 l=1.8e-07 ////Bias Transistor, should not change
PM10 (IBIASP1 IBIASP2 net047 VDD) p18 w=2.2e-07 l=1.8e-07 ////Bias Transistor, should not change
PM18 (net70 net036 VDD VDD) p18 w=2.4e-07 l=3.1e-07 m=1 //// *Load* *gm1* ``PM19``
PM19 (net036 net036 VDD VDD) p18 w=2.4e-07 l=3.1e-07 m=1 //// *Load* *gm1* ``PM18``
PM13 (net47 IBIASP2 net044 VDD) p18 w=2.62e-06 l=2.1e-07 m=1 //// *Load* *gm2*  *gmt-Input*
PM8 (net039 net70 VDD VDD) p18 w=8.8e-07 l=1.8e-07 m=1 //// *Input* *gm2*
PM7 (net044 IBIASP1 VDD VDD) p18 w=2.5e-07 l=2e-07 m=1 //// *Load* *gm2*
PM2 (VOUT net70 VDD VDD) p18 w=2.28e-06 l=3.1e-07 m=1 //// *Load* *gm3*
NM24 (net039 IBIAS1 net43 VSS) n18 w=2.9e-07 l=1.9e-07 m=1 //// *Load* *gm2*
NM23 (net045 IBIAS2 VSS VSS) n18 w=2.2e-07 l=1.8e-07 ////Bias Transistor, should not change
NM22 (IBIASP2 IBIAS1 net045 VSS) n18 w=2.2e-07 l=1.8e-07 ////Bias Transistor, should not change
NM21 (net43 IBIAS2 VSS VSS) n18 w=9.6e-07 l=1.8e-07 m=1 //// *Load* *gm2*
NM17 (net036 VINN net035 VSS) n18 w=2.7e-07 l=2e-07 m=1 //// *Input* *gm1* ``NM18``
NM18 (net70 VINP net035 VSS) n18 w=2.7e-07 l=2e-07 m=1 //// *Input* *gm1* ``NM17``
NM19 (net035 IBIAS2 VSS VSS) n18 w=2.4e-07 l=1.8e-07 m=1 //// *Current tail* *gm1*
NM9 (net47 net039 VSS VSS) n18 w=2.4e-07 l=1.8e-07 m=1 //// *Load* *gm2*
NM6 (net049 IBIAS2 VSS VSS) n18 w=2.2e-07 l=1.8e-07 ////Bias Transistor, should not change
NM4 (VOUT net47 VSS VSS) n18 w=6.02e-06 l=3.6e-07 m=1 //// *Input* *gm3*
NM8 (net43 net039 VSS VSS) n18 w=2.5e-07 l=1.9e-07 m=1 //// *Load* *gm2*
NM5 (IBIAS2 IBIAS1 net049 VSS) n18 w=2.2e-07 l=1.8e-07 ////Bias Transistor, should not change
C3 (net044 VOUT) capacitor c=9.6e-13 m=1 ////Miller cap 2
C0 (net70 VOUT) capacitor c=1e-12 m=1 ////Miller cap 1
R1 (IBIASP1 IBIASP2) resistor r=200000.00000000003////Bias Resistor, should not change
R0 (IBIAS1 IBIAS2) resistor r=200000.00000000003////Bias Resistor, should not change
ends TCFC

            V0 (VSS 0) vsource dc=0 type=dc
            V1 (VDD 0) vsource dc=1.8 type=dc
            C0 (VOUT VSS) capacitor c=2.5e-10
            I0 (VDD IBIAS1) isource dc=1e-06 type=dc
                        I2 (VDD IBIAS2) isource dc=1e-06 type=dc
            I1 (VOUT VINP VOUT IBIAS1 IBIAS2 VDD VSS) TCFC
            V2 (VINP 0) vsource type=pulse val0=1.2 val1=0.6 period=5e-05 rise=1p fall=1p
