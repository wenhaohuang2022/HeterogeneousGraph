simulator lang=spectre
global 0
include "/Business/EDA_yf_company/public/PDK/smic/18/SPDK18MSE_1833_OA_CDS_V1.11_4/smic18mse_1833_1P3M_2Ia_1TMa1_MIM10_oa_cds_2019_01_15_v1.11_4/smic18mmrf/../models/spectre/ms018_enhanced_v1p11_spe.lib" section=tt
include "/Business/EDA_yf_company/public/PDK/smic/18/SPDK18MSE_1833_OA_CDS_V1.11_4/smic18mse_1833_1P3M_2Ia_1TMa1_MIM10_oa_cds_2019_01_15_v1.11_4/smic18mmrf/../models/spectre/ms018_enhanced_v1p11_spe.lib" section=bjt_tt
include "/Business/EDA_yf_company/public/PDK/smic/18/SPDK18MSE_1833_OA_CDS_V1.11_4/smic18mse_1833_1P3M_2Ia_1TMa1_MIM10_oa_cds_2019_01_15_v1.11_4/smic18mmrf/../models/spectre/ms018_enhanced_v1p11_spe.lib" section=dio_tt
include "/Business/EDA_yf_company/public/PDK/smic/18/SPDK18MSE_1833_OA_CDS_V1.11_4/smic18mse_1833_1P3M_2Ia_1TMa1_MIM10_oa_cds_2019_01_15_v1.11_4/smic18mmrf/../models/spectre/ms018_enhanced_v1p11_spe.lib" section=res_tt
include "/Business/EDA_yf_company/public/PDK/smic/18/SPDK18MSE_1833_OA_CDS_V1.11_4/smic18mse_1833_1P3M_2Ia_1TMa1_MIM10_oa_cds_2019_01_15_v1.11_4/smic18mmrf/../models/spectre/ms018_enhanced_v1p11_spe.lib" section=mim_tt
include "/Business/EDA_yf_company/public/PDK/smic/18/SPDK18MSE_1833_OA_CDS_V1.11_4/smic18mse_1833_1P3M_2Ia_1TMa1_MIM10_oa_cds_2019_01_15_v1.11_4/smic18mmrf/../models/spectre/ms018_enhanced_v1p11_spe.lib" section=var_tt

subckt AZC VINN VINP VOUT IBIAS VDD VSS
C5 (net125 VSS) capacitor c=8e-13 m=1 //// *C_z*
C0 (net135 VOUT) capacitor c=7.92e-13 m=1 //// Miller cap
NM17 (VOUT net053 VSS VSS) n18 w=8.7e-07 l=3.1e-07 m=1 //// *Input* *gm3*
NM16 (net053 net031 VSS VSS) n18 w=1.263e-05 l=2.2e-07 m=1 //// *Load* *gm2* *Input* *gm2b*
NM15 (net055 net134 VSS VSS) n18 w=9.3e-07 l=1.8e-07 m=1 ////*Input* *gma* ``NM14``
NM14 (net057 net135 VSS VSS) n18 w=9.3e-07 l=1.8e-07 m=1 ////*Input* *gma* ``NM15``
NM3 (net052 net057 net135 VSS) n18 w=1.918e-05 l=2.8e-07 m=3 //// *Load* *gm1* ``NM2``
NM2 (net050 net055 net134 VSS) n18 w=1.918e-05 l=2.8e-07 m=3 //// *Load* *gm1* ``NM3``
NM22 (IBIASP2 IBIAS net140 VSS) n18 w=2.2e-07 l=1.8e-07 ////Bias Transistor, should not change
NM5 (IBIAS2 IBIAS net141 VSS) n18 w=2.2e-07 l=1.8e-07 ////Bias Transistor, should not change
NM7 (net031 net125 VSS VSS) n18 w=1.484e-05 l=3.1e-07 m=3 //// *Load* *gm2* *Input* *gm2a*
NM1 (net134 IBIAS2 VSS VSS) n18 w=1.53e-06 l=2.6e-07 m=1 //// *Load* *gm1* ``NM0``
NM23 (net140 IBIAS2 VSS VSS) n18 w=2.2e-07 l=1.8e-07 ////Bias Transistor, should not change
NM6 (net141 IBIAS2 VSS VSS) n18 w=2.2e-07 l=1.8e-07 ////Bias Transistor, should not change
NM0 (net135 IBIAS2 VSS VSS) n18 w=1.53e-06 l=2.6e-07 m=1 //// *Load* *gm1* ``NM1``
R11 (net031 net125) resistor r=65800.0 m=1 //// *R_z*
R9 (net055 net046) resistor r=78400.0 m=1 //// *R_a* ``R8``
R8 (net057 net046) resistor r=78400.0 m=1 //// *R_a* ``R9``
R0 (IBIAS IBIAS2) resistor r=200000.00000000003////Bias Resistor, should not change
R1 (IBIASP1 IBIASP2) resistor r=200000.00000000003////Bias Resistor, should not change
PM14 (net046 IBIASP1 VDD VDD) p18 w=9.6e-07 l=1.8e-07 m=1 ////*Load* *gma*
PM7 (VOUT net052 VDD VDD) p18 w=9.7e-07 l=1.8e-07 m=1 //// *Load* *gm3*
PM6 (net053 net050 VDD VDD) p18 w=9.84e-06 l=6.8e-07 m=1 //// *Load* *gm2*
PM5 (net031 net052 VDD VDD) p18 w=7.1e-06 l=2.2e-07 m=1 //// *Input* *gm2*
PM4 (net050 net050 VDD VDD) p18 w=2.3e-07 l=1.8e-07 m=1 //// *Load* *gm1* ``PM3``
PM3 (net052 net050 VDD VDD) p18 w=2.3e-07 l=1.8e-07 m=1 //// *Load* *gm1* ``PM4``
PM2 (net118 IBIASP1 VDD VDD) p18 w=1.85e-06 l=4.8e-07 m=1 //// *Current tail* *gm1*
PM11 (net139 IBIASP1 VDD VDD) p18 w=2.2e-07 l=1.8e-07 ////Bias Transistor, should not change
PM1 (net135 VINP net118 VDD) p18 w=1.01e-06 l=5.5e-07 m=1 //// *Input* *gm1* ``PM0``
PM0 (net134 VINN net118 VDD) p18 w=1.01e-06 l=5.5e-07 m=1 //// *Input* *gm1* ``PM1``
PM10 (IBIASP1 IBIASP2 net139 VDD) p18 w=2.2e-07 l=1.8e-07 ////Bias Transistor, should not change
ends AZC

            V0 (VSS 0) vsource dc=0 type=dc
            V1 (VDD 0) vsource dc=1.8 type=dc
            C0 (VOUT VSS) capacitor c=5e-10
            I0 (VDD IBIAS) isource dc=1e-06 type=dc
            I1 (VOUT VINP VOUT IBIAS VDD VSS) AZC
            V2 (VINP 0) vsource type=pulse val0=1.2 val1=0.6 period=3.3333333333333335e-05 rise=1p fall=1p
