simulator lang=spectre
global 0
include "/Business/EDA_yf_company/public/PDK/smic/18/SPDK18MSE_1833_OA_CDS_V1.11_4/smic18mse_1833_1P3M_2Ia_1TMa1_MIM10_oa_cds_2019_01_15_v1.11_4/smic18mmrf/../models/spectre/ms018_enhanced_v1p11_spe.lib" section=tt
include "/Business/EDA_yf_company/public/PDK/smic/18/SPDK18MSE_1833_OA_CDS_V1.11_4/smic18mse_1833_1P3M_2Ia_1TMa1_MIM10_oa_cds_2019_01_15_v1.11_4/smic18mmrf/../models/spectre/ms018_enhanced_v1p11_spe.lib" section=bjt_tt
include "/Business/EDA_yf_company/public/PDK/smic/18/SPDK18MSE_1833_OA_CDS_V1.11_4/smic18mse_1833_1P3M_2Ia_1TMa1_MIM10_oa_cds_2019_01_15_v1.11_4/smic18mmrf/../models/spectre/ms018_enhanced_v1p11_spe.lib" section=dio_tt
include "/Business/EDA_yf_company/public/PDK/smic/18/SPDK18MSE_1833_OA_CDS_V1.11_4/smic18mse_1833_1P3M_2Ia_1TMa1_MIM10_oa_cds_2019_01_15_v1.11_4/smic18mmrf/../models/spectre/ms018_enhanced_v1p11_spe.lib" section=res_tt
include "/Business/EDA_yf_company/public/PDK/smic/18/SPDK18MSE_1833_OA_CDS_V1.11_4/smic18mse_1833_1P3M_2Ia_1TMa1_MIM10_oa_cds_2019_01_15_v1.11_4/smic18mmrf/../models/spectre/ms018_enhanced_v1p11_spe.lib" section=mim_tt
include "/Business/EDA_yf_company/public/PDK/smic/18/SPDK18MSE_1833_OA_CDS_V1.11_4/smic18mse_1833_1P3M_2Ia_1TMa1_MIM10_oa_cds_2019_01_15_v1.11_4/smic18mmrf/../models/spectre/ms018_enhanced_v1p11_spe.lib" section=var_tt

subckt IAC VINN VINP VOUT IBIAS VDD VSS
C1 (net045 VSS) capacitor c=1.05e-12 m=1 //// *C_a*
C0 (net035 VOUT) capacitor c=8.9e-13 m=1 //// Miller cap

NM15 (net51 IBIAS2 VSS VSS) n18 w=3.25e-06 l=2.2e-07 m=1 //// *Load* *gm2*
NM14 (net021 IBIAS net51 VSS) n18 w=1.97e-06 l=8.6e-07 m=1 //// *Load* *gm2*
NM12 (net012 IBIAS2 VSS VSS) n18 w=6.8e-07 l=1.8e-07 m=1 //// *Current tail* *gm1*
NM11 (net035 VINP net012 VSS) n18 w=3.9e-07 l=2.3e-07 m=1 //// *Input* *gm1* ``NM10``
NM10 (net013 VINN net012 VSS) n18 w=3.9e-07 l=2.3e-07 m=1 //// *Input* *gm1* ``NM11``
NM8 (VOUT net55 VSS VSS) n18 w=2.4e-07 l=1.9e-07 m=1 //// *Input* *gm3*
NM7 (net51 net021 VSS VSS) n18 w=3.17e-06 l=2.3e-07 m=1 //// *Load* *gm2* ``NM4``
NM4 (net55 net021 VSS VSS) n18 w=3.17e-06 l=2.3e-07 m=1 //// *Load* *gm2* ``NM7``
R2 (net55 net045) resistor r=712000.0 l=1.8e-07 m=1 ////*R_A*
PM9 (net013 net013 VDD VDD) p18 w=2.3e-07 l=1.8e-07 m=1 //// *Load* *gm1* ``PM8``
PM8 (net035 net013 VDD VDD) p18 w=2.3e-07 l=1.8e-07 m=1 //// *Load* *gm1* ``PM9``
PM7 (VOUT net035 VDD VDD) p18 w=3.1e-07 l=1.8e-07 m=1 //// *Load* *gm3* *Input* *gmf*
PM06 (net021 net035 VDD VDD) p18 w=4.87e-06 l=6.6e-07 m=1 //// *Input* *gm2*
PM5 (net055 IBIASP1 VDD VDD) p18 w=4.94e-06 l=1.9e-07 m=1 //// *Load* *gm2*  ``PM12``
PM12 (net55 IBIASP2 net055 VDD) p18 w=4.94e-06 l=1.9e-07 m=1 //// *Load* *gm2* ``PM5``
PM11 (net67 IBIASP1 VDD VDD) p18 w=2.2e-07 l=1.8e-07 ////Bias Transistor, should not change
PM10 (IBIASP1 IBIASP2 net67 VDD) p18 w=2.2e-07 l=1.8e-07 ////Bias Transistor, should not change
NM22 (IBIASP2 IBIAS net68 VSS) n18 w=2.2e-07 l=1.8e-07 ////Bias Transistor, should not change
NM5 (IBIAS2 IBIAS net69 VSS) n18 w=2.2e-07 l=1.8e-07 ////Bias Transistor, should not change
NM23 (net68 IBIAS2 VSS VSS) n18 w=2.2e-07 l=1.8e-07 ////Bias Transistor, should not change
NM6 (net69 IBIAS2 VSS VSS) n18 w=2.2e-07 l=1.8e-07 ////Bias Transistor, should not change
R0 (IBIAS IBIAS2) resistor r=200000.00000000003////Bias Resistor, should not change
R1 (IBIASP1 IBIASP2) resistor r=200000.00000000003////Bias Resistor, should not change
ends IAC

            V0 (VSS 0) vsource dc=0 type=dc
            V1 (VDD 0) vsource dc=1.8 type=dc
            C0 (VOUT VSS) capacitor c=1.5e-10
            I0 (VDD IBIAS) isource dc=1e-06 type=dc
            I1 (VOUT VINP VOUT IBIAS VDD VSS) IAC
            V2 (VINP 0) vsource type=pulse val0=1.2 val1=0.6 period=3.3333333333333335e-05 rise=1p fall=1p
